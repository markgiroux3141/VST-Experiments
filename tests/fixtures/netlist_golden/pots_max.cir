* Fairchild 670, one channel: generated by varimu.circuit.netlist
* 6386_a: tabulated plate current (varimu.devices.table)
.subckt TRIODE_6386_A p g k
a_ip %vd(g k) %vd(p k) %id(p k) tab_triode_6386_a
.model tab_triode_6386_a table2d(offset=0 gain=1 order=3 file="v6386_a.tab")
Bg g k I={0.004*pow(0.05*(max((V(g,k)-(-0.7))/0.05,0)+ln(1+exp(-abs((V(g,k)-(-0.7))/0.05)))),1.5)}
Cgk g k 8e-12
Cgp g p 4.8e-12
Cpk p k 4.4e-12
.ends TRIODE_6386_A

* 6386_b: tabulated plate current (varimu.devices.table)
.subckt TRIODE_6386_B p g k
a_ip %vd(g k) %vd(p k) %id(p k) tab_triode_6386_b
.model tab_triode_6386_b table2d(offset=0 gain=1 order=3 file="v6386_b.tab")
Bg g k I={0.004*pow(0.05*(max((V(g,k)-(-0.7))/0.05,0)+ln(1+exp(-abs((V(g,k)-(-0.7))/0.05)))),1.5)}
Cgk g k 8e-12
Cgp g p 4.8e-12
Cpk p k 4.4e-12
.ends TRIODE_6386_B

* 12AX7: tabulated plate current (varimu.devices.table)
.subckt TRIODE_12AX7 p g k
a_ip %vd(g k) %vd(p k) %id(p k) tab_triode_12ax7
.model tab_triode_12ax7 table2d(offset=0 gain=1 order=3 file="v12ax7.tab")
Bg g k I={0.001*pow(0.05*(max((V(g,k)-(-0.7))/0.05,0)+ln(1+exp(-abs((V(g,k)-(-0.7))/0.05)))),1.5)}
Cgk g k 2.3e-12
Cgp g p 2.4e-12
Cpk p k 9e-13
.ends TRIODE_12AX7

* 12BH7: tabulated plate current (varimu.devices.table)
.subckt TRIODE_12BH7 p g k
a_ip %vd(g k) %vd(p k) %id(p k) tab_triode_12bh7
.model tab_triode_12bh7 table2d(offset=0 gain=1 order=3 file="v12bh7.tab")
Bg g k I={0.001*pow(0.05*(max((V(g,k)-(-0.7))/0.05,0)+ln(1+exp(-abs((V(g,k)-(-0.7))/0.05)))),1.5)}
Cgk g k 3.2e-12
Cgp g p 2.6e-12
Cpk p k 5e-13
.ends TRIODE_12BH7

* 6973: generated by varimu.devices.pentode
.subckt PENTODE_6973 p g2 g1 k
Bp p k I={0.00104649484005964*pow(max(max(V(g2,k),0.001)/65.7217545417324*(max(65.7217545417324*(0.109199009749746+V(g1,k)/max(V(g2,k),0.001)),0)+ln(1+exp(-abs(65.7217545417324*(0.109199009749746+V(g1,k)/max(V(g2,k),0.001)))))),0),1.35)*atan(V(p,k)/27.5247648157089)}
Bg2 g2 k I={pow(max(V(g1,k)+V(g2,k)/9.15759220062275,0),1.5)/12324.7043795843}
Cg1k g1 k 9e-12
Cg1p g1 p 4e-13
Cpk p k 6e-12
.ends PENTODE_6973

.model D_SI_RECTIFIER D(IS=7e-09 N=1.8 RS=0.034)

* --- power supply ---
VBP bpi 0 dc 240
Rpsu bpi bp 10
C307A bp 0 8e-05
VBIAS vbi 0 dc -13.75
Rbias vbi vb 100
VSCB vsc 0 dc -27
* --- input ---
Rsrc in in_s 600
RAT1011 in_s AT101_m 563.215883961941
RAT1012 AT101_m pri 563.215883961941
RAT1013 AT101_m 0 37.9853172392598
R101 pri 0 360
RT101_p pri T101_p_r 20
LT101_p T101_p_r 0 0.746542280490176
RT101_sa ga T101_sa_r 400
LT101_sa T101_sa_r cv 15.1174811799261
CT101_sa ga cv 1e-10
RT101_sb cv T101_sb_r 400
LT101_sb T101_sb_r gb 15.1174811799261
CT101_sb cv gb 1e-10
* --- 6386 push-pull ---
XVA pa ga ka TRIODE_6386_A
XVB pb gb kb TRIODE_6386_B
R103 ka ta 680
R104 kb tb 680
R105a ta 0 100
R105b 0 tb 0.001
C101 ka kb 4e-06
R111 bp ctr 33
R107 ctr t3 30
R108 ctr t2 30
RT102_pa pa T102_pa_r 150
LT102_pa T102_pa_r t3 30.027645851392
CT102_pa pa t3 2e-10
RT102_pb t2 T102_pb_r 150
LT102_pb T102_pb_r pb 30.027645851392
CT102_pb t2 pb 2e-10
RT102_s out T102_s_r 10
LT102_s T102_s_r 0 1.48284670871072
Rload out 0 600
* --- sidechain input ---
R145 out s1 150
R147 0 s2 150
R149 s1 s2 1360
LT103_p s1 s2 0.441069966606171
LT103_sa t5 0 3.96962969945554
CT103_sa t5 0 1e-10
LT103_sb 0 t8 3.96962969945554
CT103_sb 0 t8 1e-10
R115Aa t5 w1a 0.001
R115Ab w1a x1a 100000
R115Ba t8 w1b 0.001
R115Bb w1b x1b 180000
R113 x1a 0 24000
R114 x1b 0 24000
* --- 12AX7 ---
XV105A p1a w1a k1 TRIODE_12AX7
XV105B p1b w1b k1 TRIODE_12AX7
R120 bp p1a 100000
R121 bp p1b 100000
R118 bp k1 1000000
R119 k1 0 18000
R116 bp dw 270000
R117a 0 dw 100000
R117b dw k1 0.001
C103 p1a g2a 5e-08
C104 p1b g2b 5e-08
* --- 12BH7 ---
R122 g2a 0 1000000
R123 g2b 0 1000000
XV106A p2a g2a k2a TRIODE_12BH7
XV106B p2b g2b k2b TRIODE_12BH7
R124 k2a 0 1000
R125 k2b 0 1000
R126 bp p2a 100000
R127 bp p2b 100000
Rfba fy k2a 2700
Rfbb fg k2b 2700
R134 fy 0 860
R135 fg 0 560
C107 p2a g3a 1e-07
C108 p2b g3b 1e-07
* --- 6973 ---
R130 g3a vsc 150000
R131 g3b vsc 150000
XV107 pa3 sa3 g3a 0 PENTODE_6973
XV108 pb3 sb3 g3b 0 PENTODE_6973
R132 bp sa3 560
R133 bp sb3 560
R143 g3a nfa 47000
C105 nfa pa3 2e-11
R144 g3b nfb 47000
C106 nfb pb3 2e-11
LT104_pa pa3 bp 9.97174325972044
CT104_pa pa3 bp 2e-10
LT104_pb bp pb3 9.97174325972044
CT104_pb bp pb3 2e-10
LT104_s ay bk 2.49293581493011
LT104_f fy fg 0.441850436774028
* --- rectifier and time constant ---
R136 ay bk 3900
Rleak bk 0 1000000000
DCR101 ay tcb D_SI_RECTIFIER
DCR102 bk tcb D_SI_RECTIFIER
DCR103 cv ay D_SI_RECTIFIER
DCR104 cv bk D_SI_RECTIFIER
R137 cv tcb 220000
C109 cv tcb 2e-06
R138 cv tcb 470000
C115 tcb 0 1e-07
R142a 0 tcb 2500
R142b tcb vb 0.001
* --- linear cores: windings coupled (leakage folded in), eddy loss ---
Lt101_core_eddy t101_core_eddy 0 0.745292280490176
Rt101_core_eddy t101_core_eddy 0 1642834.28571429
Kt101_core_0_1 LT101_p LT101_sa 0.998325613923462
Kt101_core_0_2 LT101_p LT101_sb 0.998325613923462
Kt101_core_0_3 LT101_p Lt101_core_eddy 0.99916245622194
Kt101_core_1_2 LT101_sa LT101_sb 0.998325613923462
Kt101_core_1_3 LT101_sa Lt101_core_eddy 0.999162456221941
Kt101_core_2_3 LT101_sb Lt101_core_eddy 0.999162456221941
Lt102_core_eddy t102_core_eddy 0 29.997270851392
Rt102_core_eddy t102_core_eddy 0 274223.020408163
Kt102_core_0_1 LT102_pa LT102_pb 0.998988432188446
Kt102_core_0_2 LT102_pa LT102_s 0.998988432188446
Kt102_core_0_3 LT102_pa Lt102_core_eddy 0.999494088120809
Kt102_core_1_2 LT102_pb LT102_s 0.998988432188446
Kt102_core_1_3 LT102_pb Lt102_core_eddy 0.999494088120809
Kt102_core_2_3 LT102_s Lt102_core_eddy 0.999494088120808
Lt103_core_eddy t103_core_eddy 0 0.436069966606171
Rt103_core_eddy t103_core_eddy 0 974308.5
Kt103_core_0_1 LT103_p LT103_sa 0.988663930037058
Kt103_core_0_2 LT103_p LT103_sb 0.988663930037058
Kt103_core_0_3 LT103_p Lt103_core_eddy 0.994315810010611
Kt103_core_1_2 LT103_sa LT103_sb 0.988663930037058
Kt103_core_1_3 LT103_sa Lt103_core_eddy 0.994315810010611
Kt103_core_2_3 LT103_sb Lt103_core_eddy 0.994315810010611
Lt104_core_eddy t104_core_eddy 0 9.96174325972044
Rt104_core_eddy t104_core_eddy 0 70358.2040816326
Kt104_core_0_1 LT104_pa LT104_pb 0.998997166318913
Kt104_core_0_2 LT104_pa LT104_s 0.998997166318913
Kt104_core_0_3 LT104_pa LT104_f 0.998997166318913
Kt104_core_0_4 LT104_pa Lt104_core_eddy 0.99949845738696
Kt104_core_1_2 LT104_pb LT104_s 0.998997166318913
Kt104_core_1_3 LT104_pb LT104_f 0.998997166318913
Kt104_core_1_4 LT104_pb Lt104_core_eddy 0.99949845738696
Kt104_core_2_3 LT104_s LT104_f 0.998997166318913
Kt104_core_2_4 LT104_s Lt104_core_eddy 0.99949845738696
Kt104_core_3_4 LT104_f Lt104_core_eddy 0.99949845738696
.options rshunt=1000000000000
