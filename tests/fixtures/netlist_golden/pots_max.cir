* Fairchild 670, one channel: generated by varimu.circuit.netlist
* 6386_V101A: tabulated plate current (varimu.devices.table)
.subckt TRIODE_6386_V101A p g k
a_ip %vd(g k) %vd(p k) %id(p k) tab_triode_6386_v101a
.model tab_triode_6386_v101a table2d(offset=0 gain=1 order=3 file="v6386_v101a.tab")
Bg g k I={0.001*pow(0.05*(max((V(g,k)-(-0.7))/0.05,0)+ln(1+exp(-abs((V(g,k)-(-0.7))/0.05)))),1.5)}
Cgk g k 2e-12
Cgp g p 1.2e-12
Cpk p k 1.1e-12
.ends TRIODE_6386_V101A

* 6386_V102A: tabulated plate current (varimu.devices.table)
.subckt TRIODE_6386_V102A p g k
a_ip %vd(g k) %vd(p k) %id(p k) tab_triode_6386_v102a
.model tab_triode_6386_v102a table2d(offset=0 gain=1 order=3 file="v6386_v102a.tab")
Bg g k I={0.001*pow(0.05*(max((V(g,k)-(-0.7))/0.05,0)+ln(1+exp(-abs((V(g,k)-(-0.7))/0.05)))),1.5)}
Cgk g k 2e-12
Cgp g p 1.2e-12
Cpk p k 1.1e-12
.ends TRIODE_6386_V102A

* 6386_V103B: tabulated plate current (varimu.devices.table)
.subckt TRIODE_6386_V103B p g k
a_ip %vd(g k) %vd(p k) %id(p k) tab_triode_6386_v103b
.model tab_triode_6386_v103b table2d(offset=0 gain=1 order=3 file="v6386_v103b.tab")
Bg g k I={0.001*pow(0.05*(max((V(g,k)-(-0.7))/0.05,0)+ln(1+exp(-abs((V(g,k)-(-0.7))/0.05)))),1.5)}
Cgk g k 2e-12
Cgp g p 1.2e-12
Cpk p k 1.1e-12
.ends TRIODE_6386_V103B

* 6386_V104B: tabulated plate current (varimu.devices.table)
.subckt TRIODE_6386_V104B p g k
a_ip %vd(g k) %vd(p k) %id(p k) tab_triode_6386_v104b
.model tab_triode_6386_v104b table2d(offset=0 gain=1 order=3 file="v6386_v104b.tab")
Bg g k I={0.001*pow(0.05*(max((V(g,k)-(-0.7))/0.05,0)+ln(1+exp(-abs((V(g,k)-(-0.7))/0.05)))),1.5)}
Cgk g k 2e-12
Cgp g p 1.2e-12
Cpk p k 1.1e-12
.ends TRIODE_6386_V104B

* 6386_V101B: tabulated plate current (varimu.devices.table)
.subckt TRIODE_6386_V101B p g k
a_ip %vd(g k) %vd(p k) %id(p k) tab_triode_6386_v101b
.model tab_triode_6386_v101b table2d(offset=0 gain=1 order=3 file="v6386_v101b.tab")
Bg g k I={0.001*pow(0.05*(max((V(g,k)-(-0.7))/0.05,0)+ln(1+exp(-abs((V(g,k)-(-0.7))/0.05)))),1.5)}
Cgk g k 2e-12
Cgp g p 1.2e-12
Cpk p k 1.1e-12
.ends TRIODE_6386_V101B

* 6386_V102B: tabulated plate current (varimu.devices.table)
.subckt TRIODE_6386_V102B p g k
a_ip %vd(g k) %vd(p k) %id(p k) tab_triode_6386_v102b
.model tab_triode_6386_v102b table2d(offset=0 gain=1 order=3 file="v6386_v102b.tab")
Bg g k I={0.001*pow(0.05*(max((V(g,k)-(-0.7))/0.05,0)+ln(1+exp(-abs((V(g,k)-(-0.7))/0.05)))),1.5)}
Cgk g k 2e-12
Cgp g p 1.2e-12
Cpk p k 1.1e-12
.ends TRIODE_6386_V102B

* 6386_V103A: tabulated plate current (varimu.devices.table)
.subckt TRIODE_6386_V103A p g k
a_ip %vd(g k) %vd(p k) %id(p k) tab_triode_6386_v103a
.model tab_triode_6386_v103a table2d(offset=0 gain=1 order=3 file="v6386_v103a.tab")
Bg g k I={0.001*pow(0.05*(max((V(g,k)-(-0.7))/0.05,0)+ln(1+exp(-abs((V(g,k)-(-0.7))/0.05)))),1.5)}
Cgk g k 2e-12
Cgp g p 1.2e-12
Cpk p k 1.1e-12
.ends TRIODE_6386_V103A

* 6386_V104A: tabulated plate current (varimu.devices.table)
.subckt TRIODE_6386_V104A p g k
a_ip %vd(g k) %vd(p k) %id(p k) tab_triode_6386_v104a
.model tab_triode_6386_v104a table2d(offset=0 gain=1 order=3 file="v6386_v104a.tab")
Bg g k I={0.001*pow(0.05*(max((V(g,k)-(-0.7))/0.05,0)+ln(1+exp(-abs((V(g,k)-(-0.7))/0.05)))),1.5)}
Cgk g k 2e-12
Cgp g p 1.2e-12
Cpk p k 1.1e-12
.ends TRIODE_6386_V104A

* 12AX7_V105A: tabulated plate current (varimu.devices.table)
.subckt TRIODE_12AX7_V105A p g k
a_ip %vd(g k) %vd(p k) %id(p k) tab_triode_12ax7_v105a
.model tab_triode_12ax7_v105a table2d(offset=0 gain=1 order=3 file="v12ax7_v105a.tab")
Bg g k I={0.001*pow(0.05*(max((V(g,k)-(-0.7))/0.05,0)+ln(1+exp(-abs((V(g,k)-(-0.7))/0.05)))),1.5)}
Cgk g k 2.3e-12
Cgp g p 2.4e-12
Cpk p k 9e-13
.ends TRIODE_12AX7_V105A

* 12AX7_V105B: tabulated plate current (varimu.devices.table)
.subckt TRIODE_12AX7_V105B p g k
a_ip %vd(g k) %vd(p k) %id(p k) tab_triode_12ax7_v105b
.model tab_triode_12ax7_v105b table2d(offset=0 gain=1 order=3 file="v12ax7_v105b.tab")
Bg g k I={0.001*pow(0.05*(max((V(g,k)-(-0.7))/0.05,0)+ln(1+exp(-abs((V(g,k)-(-0.7))/0.05)))),1.5)}
Cgk g k 2.3e-12
Cgp g p 2.4e-12
Cpk p k 9e-13
.ends TRIODE_12AX7_V105B

* 12BH7_V106A: tabulated plate current (varimu.devices.table)
.subckt TRIODE_12BH7_V106A p g k
a_ip %vd(g k) %vd(p k) %id(p k) tab_triode_12bh7_v106a
.model tab_triode_12bh7_v106a table2d(offset=0 gain=1 order=3 file="v12bh7_v106a.tab")
Bg g k I={0.001*pow(0.05*(max((V(g,k)-(-0.7))/0.05,0)+ln(1+exp(-abs((V(g,k)-(-0.7))/0.05)))),1.5)}
Cgk g k 3.2e-12
Cgp g p 2.6e-12
Cpk p k 5e-13
.ends TRIODE_12BH7_V106A

* 12BH7_V106B: tabulated plate current (varimu.devices.table)
.subckt TRIODE_12BH7_V106B p g k
a_ip %vd(g k) %vd(p k) %id(p k) tab_triode_12bh7_v106b
.model tab_triode_12bh7_v106b table2d(offset=0 gain=1 order=3 file="v12bh7_v106b.tab")
Bg g k I={0.001*pow(0.05*(max((V(g,k)-(-0.7))/0.05,0)+ln(1+exp(-abs((V(g,k)-(-0.7))/0.05)))),1.5)}
Cgk g k 3.2e-12
Cgp g p 2.6e-12
Cpk p k 5e-13
.ends TRIODE_12BH7_V106B

* 6973_V107: generated by varimu.devices.pentode
.subckt PENTODE_6973_V107 p g2 g1 k
Bp p k I={0.00104649484005964*pow(max(max(V(g2,k),0.001)/65.7217545417324*(max(65.7217545417324*(0.109199009749746+V(g1,k)/max(V(g2,k),0.001)),0)+ln(1+exp(-abs(65.7217545417324*(0.109199009749746+V(g1,k)/max(V(g2,k),0.001)))))),0),1.35)*atan(V(p,k)/27.5247648157089)}
Bg2 g2 k I={pow(max(V(g1,k)+V(g2,k)/9.15759220062275,0),1.5)/12324.7043795843}
Bg1 g1 k I={0.001*pow(0.05*(max((V(g1,k)-(-0.7))/0.05,0)+ln(1+exp(-abs((V(g1,k)-(-0.7))/0.05)))),1.5)}
Cg1k g1 k 9e-12
Cg1p g1 p 4e-13
Cpk p k 6e-12
.ends PENTODE_6973_V107

* 6973_V108: generated by varimu.devices.pentode
.subckt PENTODE_6973_V108 p g2 g1 k
Bp p k I={0.00104649484005964*pow(max(max(V(g2,k),0.001)/65.7217545417324*(max(65.7217545417324*(0.109199009749746+V(g1,k)/max(V(g2,k),0.001)),0)+ln(1+exp(-abs(65.7217545417324*(0.109199009749746+V(g1,k)/max(V(g2,k),0.001)))))),0),1.35)*atan(V(p,k)/27.5247648157089)}
Bg2 g2 k I={pow(max(V(g1,k)+V(g2,k)/9.15759220062275,0),1.5)/12324.7043795843}
Bg1 g1 k I={0.001*pow(0.05*(max((V(g1,k)-(-0.7))/0.05,0)+ln(1+exp(-abs((V(g1,k)-(-0.7))/0.05)))),1.5)}
Cg1k g1 k 9e-12
Cg1p g1 p 4e-13
Cpk p k 6e-12
.ends PENTODE_6973_V108

.model D_SI_RECTIFIER D(IS=7e-09 N=1.8 RS=0.034)

* GZ34_V301: generated by varimu.devices.diode
.subckt VDIODE_GZ34_V301 a k
Ba a k I={0.00388773931460273*pow(0.1*(max(V(a,k)/0.1,0)+ln(1+exp(-abs(V(a,k)/0.1)))),1.5)}
.ends VDIODE_GZ34_V301

* EL34T_V302: tabulated plate current (varimu.devices.table)
.subckt TRIODE_EL34T_V302 p g k
a_ip %vd(g k) %vd(p k) %id(p k) tab_triode_el34t_v302
.model tab_triode_el34t_v302 table2d(offset=0 gain=1 order=3 file="vel34t_v302.tab")
Bg g k I={0.001*pow(0.05*(max((V(g,k)-(-0.7))/0.05,0)+ln(1+exp(-abs((V(g,k)-(-0.7))/0.05)))),1.5)}
Cgk g k 1.52e-11
Cgp g p 1e-12
Cpk p k 8.4e-12
.ends TRIODE_EL34T_V302

* 6084_V303: generated by varimu.devices.pentode
.subckt PENTODE_6084_V303 p g2 g1 k
Bp p k I={0.000828099035229684*pow(max(max(V(g2,k),0.001)/204.085613449016*(max(204.085613449016*(0.0403529271676221+V(g1,k)/max(V(g2,k),0.001)),0)+ln(1+exp(-abs(204.085613449016*(0.0403529271676221+V(g1,k)/max(V(g2,k),0.001)))))),0),1.21416918784905)*atan(V(p,k)/6.71323467131325)}
Bg2 g2 k I={pow(max(V(g1,k)+V(g2,k)/24.7813497109168,0),1.5)/5048.1683159843}
Bg1 g1 k I={0.001*pow(0.05*(max((V(g1,k)-(-0.7))/0.05,0)+ln(1+exp(-abs((V(g1,k)-(-0.7))/0.05)))),1.5)}
Cg1k g1 k 5e-12
Cg1p g1 p 2.5e-14
Cpk p k 7.3e-12
.ends PENTODE_6084_V303

.model D_5651 D(IS=1e-09 N=1 RS=888.119124733381)

.model D_SELENIUM_GR301 D(IS=2.80284394404716e-05 N=2.49079300895947 RS=0.855139711066827)

* 6386_CH2: tabulated plate current (varimu.devices.table)
.subckt TRIODE_6386_CH2 p g k
a_ip %vd(g k) %vd(p k) %id(p k) tab_triode_6386_ch2
.model tab_triode_6386_ch2 table2d(offset=0 gain=1 order=3 file="v6386_ch2.tab")
Bg g k I={0.008*pow(0.05*(max((V(g,k)-(-0.7))/0.05,0)+ln(1+exp(-abs((V(g,k)-(-0.7))/0.05)))),1.5)}
Cgk g k 1.6e-11
Cgp g p 9.6e-12
Cpk p k 8.8e-12
.ends TRIODE_6386_CH2

* 12BH7_CH2: tabulated plate current (varimu.devices.table)
.subckt TRIODE_12BH7_CH2 p g k
a_ip %vd(g k) %vd(p k) %id(p k) tab_triode_12bh7_ch2
.model tab_triode_12bh7_ch2 table2d(offset=0 gain=1 order=3 file="v12bh7_ch2.tab")
Bg g k I={0.002*pow(0.05*(max((V(g,k)-(-0.7))/0.05,0)+ln(1+exp(-abs((V(g,k)-(-0.7))/0.05)))),1.5)}
Cgk g k 6.4e-12
Cgp g p 5.2e-12
Cpk p k 1e-12
.ends TRIODE_12BH7_CH2

* 6973_CH2: generated by varimu.devices.pentode
.subckt PENTODE_6973_CH2 p g2 g1 k
Bp p k I={0.00209298968011928*pow(max(max(V(g2,k),0.001)/65.7217545417324*(max(65.7217545417324*(0.109199009749746+V(g1,k)/max(V(g2,k),0.001)),0)+ln(1+exp(-abs(65.7217545417324*(0.109199009749746+V(g1,k)/max(V(g2,k),0.001)))))),0),1.35)*atan(V(p,k)/27.5247648157089)}
Bg2 g2 k I={pow(max(V(g1,k)+V(g2,k)/9.15759220062275,0),1.5)/6162.35218979213}
Bg1 g1 k I={0.002*pow(0.05*(max((V(g1,k)-(-0.7))/0.05,0)+ln(1+exp(-abs((V(g1,k)-(-0.7))/0.05)))),1.5)}
Cg1k g1 k 1.8e-11
Cg1p g1 p 8e-13
Cpk p k 1.2e-11
.ends PENTODE_6973_CH2

* --- power supply ---
VHVA hva 0 dc 571.766543267442 sin(0 571.766543267442 60 0 0 90)
VHVB hvb 0 dc -571.766543267442 sin(0 571.766543267442 60 0 0 270)
RT302A hva hva_r 60
LT302A hva_r rka 0.005
RT302B hvb hvb_r 60
LT302B hvb_r rkb 0.005
CT302A rka 0 3e-10
CT302B rkb 0 3e-10
XV301A rka raw VDIODE_GZ34_V301
XV301B rkb raw VDIODE_GZ34_V301
C304 raw 0 4e-06
RL301 raw l301 71
L301 l301 ur 10
C305 ur c305 0.00014
R305 ur c305 100000
C306 c305 0 0.00014
R306 c305 0 100000
XV302 ur eg bp TRIODE_EL34T_V302
R309 ur eg 470000
XV303 eg es eadj ref PENTODE_6084_V303
R310 bp es 100000
R311 es ref 270000
DV304 ref ref_v D_5651
V304 ref_v 0 dc 84.398665360093
R312 bp adj_t 150000
R313a adj_t eadj 181250
R313b eadj adj_b 68750
R314 adj_b 0 100000
C307A bp 0 8e-05
R315 bp sg 27000
R316 sg 0 100000
C307B sg 0 6e-05
R307 bp hct 100000
R308 hct 0 100000
* --- bias supply ---
VBS bs1 bsb dc 37.900923471599 sin(0 37.900923471599 60 0 0 90)
RT301 bs1 bs1_r 1
LT301 bs1_r bsa 0.001
Rbsleak bsb 0 1000000000
DGR301A bsa 0 D_SELENIUM_GR301
DGR301B bsb 0 D_SELENIUM_GR301
DGR301C nb1 bsa D_SELENIUM_GR301
DGR301D nb1 bsb D_SELENIUM_GR301
CGR301A bsa 0 1.25e-07
CGR301B bsb 0 1.25e-07
CGR301C nb1 bsa 1.25e-07
CGR301D nb1 bsb 1.25e-07
C302 nb1 0 0.00025
RL302 nb1 l302 284
L302 l302 nb2 5
C303 nb2 0 0.001
R301 nb1 nb3 1000
C108B nb3 0 0.00025
R302 nb3 nb4 10000
C308 nb4 0 2.5e-05
R303 nb4 0 27000
* --- channel 2 (idle, lumped) ---
R211 bp p6c2 123
XV2_6386 p6c2 g6c2 k6c2 TRIODE_6386_CH2
R203 k6c2 nb2 363.287671232877
R242a 0 g6c2 2500
R242b g6c2 nb3 0.001
R216 bp dw2 270000
R217a 0 dw2 100000
R217b dw2 k1c2 0.001
R218 bp k1c2 1000000
R219 k1c2 0 18000
R226 ur p2c2 50000
XV2_12BH7 p2c2 0 k2c2 TRIODE_12BH7_CH2
R224 k2c2 0 385.800681979026
XV2_6973 ur s3c2 g3c2 0 PENTODE_6973_CH2
R232 sg s3c2 280
R230 g3c2 nb4 75000
* --- input ---
Rsrc in in_s 600
RAT1011 in_s AT101_m 563.215883961941
RAT1012 AT101_m pri 563.215883961941
RAT1013 AT101_m 0 37.9853172392598
R101 pri 0 360
RT101_p pri T101_p_r 20
LT101_p T101_p_r 0 17.6705519196124
RT101_sa ga T101_sa_r 400
LT101_sa T101_sa_r cv 357.828676372151
CT101_sa ga cv 1e-10
RT101_sb cv T101_sb_r 400
LT101_sb T101_sb_r gb 357.828676372151
CT101_sb cv gb 1e-10
* --- 6386 push-pull ---
XV101A pa ga ka TRIODE_6386_V101A
XV102A pa ga ka TRIODE_6386_V102A
XV103B pa ga ka TRIODE_6386_V103B
XV104B pa ga ka TRIODE_6386_V104B
XV101B pb gb kb TRIODE_6386_V101B
XV102B pb gb kb TRIODE_6386_V102B
XV103A pb gb kb TRIODE_6386_V103A
XV104A pb gb kb TRIODE_6386_V104A
R103 ka ta 680
R104 kb tb 680
R105a ta nb2 100
R105b nb2 tb 0.001
C101 ka kb 4e-06
R111 bp ctr 33
R107 ctr t3 30
R108 ctr t2 30
RT102_pa pa T102_pa_r 150
LT102_pa T102_pa_r t3 30.027645851392
CT102_pa pa t3 2e-10
RT102_pb t2 T102_pb_r 150
LT102_pb T102_pb_r pb 30.027645851392
CT102_pb t2 pb 2e-10
RT102_s out T102_s_r 10
LT102_s T102_s_r 0 1.48284670871072
Rload out 0 600
* --- sidechain input ---
R145 out s1 150
R147 0 s2 150
R149 s1 s2 1360
LT103_p s1 s2 7.92442698797914
LT103_sa t5 0 572.539849881493
CT103_sa t5 0 1e-10
LT103_sb 0 t8 572.539849881493
CT103_sb 0 t8 1e-10
R115Aa 0 x1a 50000
R115Ab x1a w1a 50000
R115Ac w1a t5 0.001
R115Ba 0 x1b 50000
R115Bb x1b w1b 50000
R115Bc w1b t8 0.001
R113 x1a 0 24000
R114 x1b 0 24000
* --- 12AX7 ---
XV105A p1a w1a k1 TRIODE_12AX7_V105A
XV105B p1b w1b k1 TRIODE_12AX7_V105B
R120 bp p1a 100000
R121 bp p1b 100000
R118 bp k1 1000000
R119 k1 0 18000
R116 bp dw 270000
R117a 0 dw 100000
R117b dw k1 0.001
C103 p1a g2a 5e-08
C104 p1b g2b 5e-08
* --- 12BH7 ---
R122 g2a 0 1000000
R123 g2b 0 1000000
XV106A p2a g2a k2a TRIODE_12BH7_V106A
XV106B p2b g2b k2b TRIODE_12BH7_V106B
R124 k2a 0 1000
R125 k2b 0 1000
R126 ur p2a 100000
R127 ur p2b 100000
R128 fy k2a 2700
R129 fg k2b 2700
R134 fy 0 860
R135 fg 0 560
C107 p2a g3a 1e-07
C108 p2b g3b 1e-07
* --- 6973 ---
R130 g3a nb4 150000
R131 g3b nb4 150000
XV107 pa3 sa3 g3a 0 PENTODE_6973_V107
XV108 pb3 sb3 g3b 0 PENTODE_6973_V108
R132 sg sa3 560
R133 sg sb3 560
R143 g3a nfa 47000
C105 nfa pa3 2e-11
R144 g3b nfb 47000
C106 nfb pb3 2e-11
LT104_pa pa3 ur 9.97174325972044
CT104_pa pa3 ur 2e-10
LT104_pb ur pb3 9.97174325972044
CT104_pb ur pb3 2e-10
LT104_s ay bk 2.49293581493011
CT104_s ay bk 1e-10
LT104_f fy fg 0.441850436774028
* --- rectifier and time constant ---
R136 ay bk 3900
Rleak bk 0 1000000000
DCR101 ay tcb D_SI_RECTIFIER
DCR102 bk tcb D_SI_RECTIFIER
DCR103 cv ay D_SI_RECTIFIER
DCR104 cv bk D_SI_RECTIFIER
R137 cv tcb 220000
C109 cv tcb 2e-06
R138 cv tcb 470000
C115 tcb 0 1e-07
R142a 0 tcb 2500
R142b tcb nb3 0.001
* --- linear cores: windings coupled (leakage folded in), eddy loss ---
Lt101_core_eddy t101_core_eddy 0 17.6693019196124
Rt101_core_eddy t101_core_eddy 0 1642834.28571429
Kt101_core_0_1 LT101_p LT101_sa 0.999929260839973
Kt101_core_0_2 LT101_p LT101_sb 0.999929260839973
Kt101_core_0_3 LT101_p Lt101_core_eddy 0.999964629794461
Kt101_core_1_2 LT101_sa LT101_sb 0.999929260839973
Kt101_core_1_3 LT101_sa Lt101_core_eddy 0.999964629794461
Kt101_core_2_3 LT101_sb Lt101_core_eddy 0.999964629794461
Lt102_core_eddy t102_core_eddy 0 29.997270851392
Rt102_core_eddy t102_core_eddy 0 274223.020408163
Kt102_core_0_1 LT102_pa LT102_pb 0.998988432188446
Kt102_core_0_2 LT102_pa LT102_s 0.998988432188446
Kt102_core_0_3 LT102_pa Lt102_core_eddy 0.999494088120809
Kt102_core_1_2 LT102_pb LT102_s 0.998988432188446
Kt102_core_1_3 LT102_pb Lt102_core_eddy 0.999494088120809
Kt102_core_2_3 LT102_s Lt102_core_eddy 0.999494088120808
Lt103_core_eddy t103_core_eddy 0 7.92192698797914
Rt103_core_eddy t103_core_eddy 0 974308.5
Kt103_core_0_1 LT103_p LT103_sa 0.999684519776156
Kt103_core_0_2 LT103_p LT103_sb 0.999684519776156
Kt103_core_0_3 LT103_p Lt103_core_eddy 0.999842247445144
Kt103_core_1_2 LT103_sa LT103_sb 0.999684519776156
Kt103_core_1_3 LT103_sa Lt103_core_eddy 0.999842247445144
Kt103_core_2_3 LT103_sb Lt103_core_eddy 0.999842247445144
Lt104_core_eddy t104_core_eddy 0 9.96174325972044
Rt104_core_eddy t104_core_eddy 0 70358.2040816326
Kt104_core_0_1 LT104_pa LT104_pb 0.998997166318913
Kt104_core_0_2 LT104_pa LT104_s 0.998997166318913
Kt104_core_0_3 LT104_pa LT104_f 0.998997166318913
Kt104_core_0_4 LT104_pa Lt104_core_eddy 0.99949845738696
Kt104_core_1_2 LT104_pb LT104_s 0.998997166318913
Kt104_core_1_3 LT104_pb LT104_f 0.998997166318913
Kt104_core_1_4 LT104_pb Lt104_core_eddy 0.99949845738696
Kt104_core_2_3 LT104_s LT104_f 0.998997166318913
Kt104_core_2_4 LT104_s Lt104_core_eddy 0.99949845738696
Kt104_core_3_4 LT104_f Lt104_core_eddy 0.99949845738696
.options rshunt=1000000000000
