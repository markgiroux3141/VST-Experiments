* Fairchild 670, one channel: generated by varimu.circuit.netlist
* 6386_a: generated by varimu.devices.triode
.subckt TRIODE_6386_A p g k
Bp p k I={(0.00285068332945394*pow(max(V(p,k)/686.339750712398*(max(686.339750712398*(0.0262185082181018+V(g,k)/sqrt(154.542793692796+V(p,k)*V(p,k))),0)+ln(1+exp(-abs(686.339750712398*(0.0262185082181018+V(g,k)/sqrt(154.542793692796+V(p,k)*V(p,k))))))),0),1.59635020230004))+(0.00125717359593969*pow(max(V(p,k)/686.339750712398*(max(686.339750712398*(0.0371358723724235+V(g,k)/sqrt(154.542793692796+V(p,k)*V(p,k))),0)+ln(1+exp(-abs(686.339750712398*(0.0371358723724235+V(g,k)/sqrt(154.542793692796+V(p,k)*V(p,k))))))),0),1.59635020230004))+(0.000598032764032466*pow(max(V(p,k)/686.339750712398*(max(686.339750712398*(0.0480532365267452+V(g,k)/sqrt(154.542793692796+V(p,k)*V(p,k))),0)+ln(1+exp(-abs(686.339750712398*(0.0480532365267452+V(g,k)/sqrt(154.542793692796+V(p,k)*V(p,k))))))),0),1.59635020230004))+(0.000305523182553192*pow(max(V(p,k)/686.339750712398*(max(686.339750712398*(0.0589706006810669+V(g,k)/sqrt(154.542793692796+V(p,k)*V(p,k))),0)+ln(1+exp(-abs(686.339750712398*(0.0589706006810669+V(g,k)/sqrt(154.542793692796+V(p,k)*V(p,k))))))),0),1.59635020230004))+(0.000166900960980184*pow(max(V(p,k)/686.339750712398*(max(686.339750712398*(0.0698879648353886+V(g,k)/sqrt(154.542793692796+V(p,k)*V(p,k))),0)+ln(1+exp(-abs(686.339750712398*(0.0698879648353886+V(g,k)/sqrt(154.542793692796+V(p,k)*V(p,k))))))),0),1.59635020230004))+(9.70677570020291e-05*pow(max(V(p,k)/686.339750712398*(max(686.339750712398*(0.0808053289897103+V(g,k)/sqrt(154.542793692796+V(p,k)*V(p,k))),0)+ln(1+exp(-abs(686.339750712398*(0.0808053289897103+V(g,k)/sqrt(154.542793692796+V(p,k)*V(p,k))))))),0),1.59635020230004))+(5.9840973861234e-05*pow(max(V(p,k)/686.339750712398*(max(686.339750712398*(0.091722693144032+V(g,k)/sqrt(154.542793692796+V(p,k)*V(p,k))),0)+ln(1+exp(-abs(686.339750712398*(0.091722693144032+V(g,k)/sqrt(154.542793692796+V(p,k)*V(p,k))))))),0),1.59635020230004))+(3.89346096518161e-05*pow(max(V(p,k)/686.339750712398*(max(686.339750712398*(0.102640057298354+V(g,k)/sqrt(154.542793692796+V(p,k)*V(p,k))),0)+ln(1+exp(-abs(686.339750712398*(0.102640057298354+V(g,k)/sqrt(154.542793692796+V(p,k)*V(p,k))))))),0),1.59635020230004))+(2.66190482449608e-05*pow(max(V(p,k)/686.339750712398*(max(686.339750712398*(0.113557421452675+V(g,k)/sqrt(154.542793692796+V(p,k)*V(p,k))),0)+ln(1+exp(-abs(686.339750712398*(0.113557421452675+V(g,k)/sqrt(154.542793692796+V(p,k)*V(p,k))))))),0),1.59635020230004))+(1.90403426800292e-05*pow(max(V(p,k)/686.339750712398*(max(686.339750712398*(0.124474785606997+V(g,k)/sqrt(154.542793692796+V(p,k)*V(p,k))),0)+ln(1+exp(-abs(686.339750712398*(0.124474785606997+V(g,k)/sqrt(154.542793692796+V(p,k)*V(p,k))))))),0),1.59635020230004))+(1.41869339996576e-05*pow(max(V(p,k)/686.339750712398*(max(686.339750712398*(0.135392149761319+V(g,k)/sqrt(154.542793692796+V(p,k)*V(p,k))),0)+ln(1+exp(-abs(686.339750712398*(0.135392149761319+V(g,k)/sqrt(154.542793692796+V(p,k)*V(p,k))))))),0),1.59635020230004))+(1.09632646909099e-05*pow(max(V(p,k)/686.339750712398*(max(686.339750712398*(0.146309513915641+V(g,k)/sqrt(154.542793692796+V(p,k)*V(p,k))),0)+ln(1+exp(-abs(686.339750712398*(0.146309513915641+V(g,k)/sqrt(154.542793692796+V(p,k)*V(p,k))))))),0),1.59635020230004))+(8.74852478592755e-06*pow(max(V(p,k)/686.339750712398*(max(686.339750712398*(0.157226878069962+V(g,k)/sqrt(154.542793692796+V(p,k)*V(p,k))),0)+ln(1+exp(-abs(686.339750712398*(0.157226878069962+V(g,k)/sqrt(154.542793692796+V(p,k)*V(p,k))))))),0),1.59635020230004))+(7.17760148331736e-06*pow(max(V(p,k)/686.339750712398*(max(686.339750712398*(0.168144242224284+V(g,k)/sqrt(154.542793692796+V(p,k)*V(p,k))),0)+ln(1+exp(-abs(686.339750712398*(0.168144242224284+V(g,k)/sqrt(154.542793692796+V(p,k)*V(p,k))))))),0),1.59635020230004))+(6.02808624453795e-06*pow(max(V(p,k)/686.339750712398*(max(686.339750712398*(0.179061606378606+V(g,k)/sqrt(154.542793692796+V(p,k)*V(p,k))),0)+ln(1+exp(-abs(686.339750712398*(0.179061606378606+V(g,k)/sqrt(154.542793692796+V(p,k)*V(p,k))))))),0),1.59635020230004))+(5.15989881880407e-06*pow(max(V(p,k)/686.339750712398*(max(686.339750712398*(0.189978970532927+V(g,k)/sqrt(154.542793692796+V(p,k)*V(p,k))),0)+ln(1+exp(-abs(686.339750712398*(0.189978970532927+V(g,k)/sqrt(154.542793692796+V(p,k)*V(p,k))))))),0),1.59635020230004))+(4.48198644930504e-06*pow(max(V(p,k)/686.339750712398*(max(686.339750712398*(0.200896334687249+V(g,k)/sqrt(154.542793692796+V(p,k)*V(p,k))),0)+ln(1+exp(-abs(686.339750712398*(0.200896334687249+V(g,k)/sqrt(154.542793692796+V(p,k)*V(p,k))))))),0),1.59635020230004))+(3.93344906131961e-06*pow(max(V(p,k)/686.339750712398*(max(686.339750712398*(0.211813698841571+V(g,k)/sqrt(154.542793692796+V(p,k)*V(p,k))),0)+ln(1+exp(-abs(686.339750712398*(0.211813698841571+V(g,k)/sqrt(154.542793692796+V(p,k)*V(p,k))))))),0),1.59635020230004))+(3.47261127946246e-06*pow(max(V(p,k)/686.339750712398*(max(686.339750712398*(0.222731062995892+V(g,k)/sqrt(154.542793692796+V(p,k)*V(p,k))),0)+ln(1+exp(-abs(686.339750712398*(0.222731062995892+V(g,k)/sqrt(154.542793692796+V(p,k)*V(p,k))))))),0),1.59635020230004))+(3.07060869304355e-06*pow(max(V(p,k)/686.339750712398*(max(686.339750712398*(0.233648427150214+V(g,k)/sqrt(154.542793692796+V(p,k)*V(p,k))),0)+ln(1+exp(-abs(686.339750712398*(0.233648427150214+V(g,k)/sqrt(154.542793692796+V(p,k)*V(p,k))))))),0),1.59635020230004))+(2.70759967549099e-06*pow(max(V(p,k)/686.339750712398*(max(686.339750712398*(0.244565791304536+V(g,k)/sqrt(154.542793692796+V(p,k)*V(p,k))),0)+ln(1+exp(-abs(686.339750712398*(0.244565791304536+V(g,k)/sqrt(154.542793692796+V(p,k)*V(p,k))))))),0),1.59635020230004))+(2.37051178508464e-06*pow(max(V(p,k)/686.339750712398*(max(686.339750712398*(0.255483155458858+V(g,k)/sqrt(154.542793692796+V(p,k)*V(p,k))),0)+ln(1+exp(-abs(686.339750712398*(0.255483155458858+V(g,k)/sqrt(154.542793692796+V(p,k)*V(p,k))))))),0),1.59635020230004))+(2.05165098786211e-06*pow(max(V(p,k)/686.339750712398*(max(686.339750712398*(0.266400519613179+V(g,k)/sqrt(154.542793692796+V(p,k)*V(p,k))),0)+ln(1+exp(-abs(686.339750712398*(0.266400519613179+V(g,k)/sqrt(154.542793692796+V(p,k)*V(p,k))))))),0),1.59635020230004))+(1.74773088298391e-06*pow(max(V(p,k)/686.339750712398*(max(686.339750712398*(0.277317883767501+V(g,k)/sqrt(154.542793692796+V(p,k)*V(p,k))),0)+ln(1+exp(-abs(686.339750712398*(0.277317883767501+V(g,k)/sqrt(154.542793692796+V(p,k)*V(p,k))))))),0),1.59635020230004))+(1.45902039065085e-06*pow(max(V(p,k)/686.339750712398*(max(686.339750712398*(0.288235247921823+V(g,k)/sqrt(154.542793692796+V(p,k)*V(p,k))),0)+ln(1+exp(-abs(686.339750712398*(0.288235247921823+V(g,k)/sqrt(154.542793692796+V(p,k)*V(p,k))))))),0),1.59635020230004))+(1.18841985535493e-06*pow(max(V(p,k)/686.339750712398*(max(686.339750712398*(0.299152612076144+V(g,k)/sqrt(154.542793692796+V(p,k)*V(p,k))),0)+ln(1+exp(-abs(686.339750712398*(0.299152612076144+V(g,k)/sqrt(154.542793692796+V(p,k)*V(p,k))))))),0),1.59635020230004))+(9.40386066757298e-07*pow(max(V(p,k)/686.339750712398*(max(686.339750712398*(0.310069976230466+V(g,k)/sqrt(154.542793692796+V(p,k)*V(p,k))),0)+ln(1+exp(-abs(686.339750712398*(0.310069976230466+V(g,k)/sqrt(154.542793692796+V(p,k)*V(p,k))))))),0),1.59635020230004))+(7.19740984880745e-07*pow(max(V(p,k)/686.339750712398*(max(686.339750712398*(0.320987340384788+V(g,k)/sqrt(154.542793692796+V(p,k)*V(p,k))),0)+ln(1+exp(-abs(686.339750712398*(0.320987340384788+V(g,k)/sqrt(154.542793692796+V(p,k)*V(p,k))))))),0),1.59635020230004))+(5.30500815261838e-07*pow(max(V(p,k)/686.339750712398*(max(686.339750712398*(0.331904704539109+V(g,k)/sqrt(154.542793692796+V(p,k)*V(p,k))),0)+ln(1+exp(-abs(686.339750712398*(0.331904704539109+V(g,k)/sqrt(154.542793692796+V(p,k)*V(p,k))))))),0),1.59635020230004))+(3.74922637580068e-07*pow(max(V(p,k)/686.339750712398*(max(686.339750712398*(0.342822068693431+V(g,k)/sqrt(154.542793692796+V(p,k)*V(p,k))),0)+ln(1+exp(-abs(686.339750712398*(0.342822068693431+V(g,k)/sqrt(154.542793692796+V(p,k)*V(p,k))))))),0),1.59635020230004))+(2.52958379327613e-07*pow(max(V(p,k)/686.339750712398*(max(686.339750712398*(0.353739432847753+V(g,k)/sqrt(154.542793692796+V(p,k)*V(p,k))),0)+ln(1+exp(-abs(686.339750712398*(0.353739432847753+V(g,k)/sqrt(154.542793692796+V(p,k)*V(p,k))))))),0),1.59635020230004))+(1.62223694383334e-07*pow(max(V(p,k)/686.339750712398*(max(686.339750712398*(0.364656797002075+V(g,k)/sqrt(154.542793692796+V(p,k)*V(p,k))),0)+ln(1+exp(-abs(686.339750712398*(0.364656797002075+V(g,k)/sqrt(154.542793692796+V(p,k)*V(p,k))))))),0),1.59635020230004))}
Bg g k I={0.004*pow(0.05*(max((V(g,k)-(-0.6))/0.05,0)+ln(1+exp(-abs((V(g,k)-(-0.6))/0.05)))),1.5)}
Cgk g k 8e-12
Cgp g p 4.8e-12
Cpk p k 4.4e-12
.ends TRIODE_6386_A

* 6386_b: generated by varimu.devices.triode
.subckt TRIODE_6386_B p g k
Bp p k I={(0.00391968957799916*pow(max(V(p,k)/686.339750712398*(max(686.339750712398*(0.0283808594113473+V(g,k)/sqrt(154.542793692796+V(p,k)*V(p,k))),0)+ln(1+exp(-abs(686.339750712398*(0.0283808594113473+V(g,k)/sqrt(154.542793692796+V(p,k)*V(p,k))))))),0),1.59635020230004))+(0.00172861369441707*pow(max(V(p,k)/686.339750712398*(max(686.339750712398*(0.0401986247330357+V(g,k)/sqrt(154.542793692796+V(p,k)*V(p,k))),0)+ln(1+exp(-abs(686.339750712398*(0.0401986247330357+V(g,k)/sqrt(154.542793692796+V(p,k)*V(p,k))))))),0),1.59635020230004))+(0.00082229505054464*pow(max(V(p,k)/686.339750712398*(max(686.339750712398*(0.0520163900547242+V(g,k)/sqrt(154.542793692796+V(p,k)*V(p,k))),0)+ln(1+exp(-abs(686.339750712398*(0.0520163900547242+V(g,k)/sqrt(154.542793692796+V(p,k)*V(p,k))))))),0),1.59635020230004))+(0.000420094376010639*pow(max(V(p,k)/686.339750712398*(max(686.339750712398*(0.0638341553764126+V(g,k)/sqrt(154.542793692796+V(p,k)*V(p,k))),0)+ln(1+exp(-abs(686.339750712398*(0.0638341553764126+V(g,k)/sqrt(154.542793692796+V(p,k)*V(p,k))))))),0),1.59635020230004))+(0.000229488821347753*pow(max(V(p,k)/686.339750712398*(max(686.339750712398*(0.0756519206981011+V(g,k)/sqrt(154.542793692796+V(p,k)*V(p,k))),0)+ln(1+exp(-abs(686.339750712398*(0.0756519206981011+V(g,k)/sqrt(154.542793692796+V(p,k)*V(p,k))))))),0),1.59635020230004))+(0.00013346816587779*pow(max(V(p,k)/686.339750712398*(max(686.339750712398*(0.0874696860197895+V(g,k)/sqrt(154.542793692796+V(p,k)*V(p,k))),0)+ln(1+exp(-abs(686.339750712398*(0.0874696860197895+V(g,k)/sqrt(154.542793692796+V(p,k)*V(p,k))))))),0),1.59635020230004))+(8.22813390591967e-05*pow(max(V(p,k)/686.339750712398*(max(686.339750712398*(0.0992874513414779+V(g,k)/sqrt(154.542793692796+V(p,k)*V(p,k))),0)+ln(1+exp(-abs(686.339750712398*(0.0992874513414779+V(g,k)/sqrt(154.542793692796+V(p,k)*V(p,k))))))),0),1.59635020230004))+(5.35350882712472e-05*pow(max(V(p,k)/686.339750712398*(max(686.339750712398*(0.111105216663166+V(g,k)/sqrt(154.542793692796+V(p,k)*V(p,k))),0)+ln(1+exp(-abs(686.339750712398*(0.111105216663166+V(g,k)/sqrt(154.542793692796+V(p,k)*V(p,k))))))),0),1.59635020230004))+(3.66011913368212e-05*pow(max(V(p,k)/686.339750712398*(max(686.339750712398*(0.122922981984855+V(g,k)/sqrt(154.542793692796+V(p,k)*V(p,k))),0)+ln(1+exp(-abs(686.339750712398*(0.122922981984855+V(g,k)/sqrt(154.542793692796+V(p,k)*V(p,k))))))),0),1.59635020230004))+(2.61804711850402e-05*pow(max(V(p,k)/686.339750712398*(max(686.339750712398*(0.134740747306543+V(g,k)/sqrt(154.542793692796+V(p,k)*V(p,k))),0)+ln(1+exp(-abs(686.339750712398*(0.134740747306543+V(g,k)/sqrt(154.542793692796+V(p,k)*V(p,k))))))),0),1.59635020230004))+(1.95070342495291e-05*pow(max(V(p,k)/686.339750712398*(max(686.339750712398*(0.146558512628232+V(g,k)/sqrt(154.542793692796+V(p,k)*V(p,k))),0)+ln(1+exp(-abs(686.339750712398*(0.146558512628232+V(g,k)/sqrt(154.542793692796+V(p,k)*V(p,k))))))),0),1.59635020230004))+(1.50744889500012e-05*pow(max(V(p,k)/686.339750712398*(max(686.339750712398*(0.15837627794992+V(g,k)/sqrt(154.542793692796+V(p,k)*V(p,k))),0)+ln(1+exp(-abs(686.339750712398*(0.15837627794992+V(g,k)/sqrt(154.542793692796+V(p,k)*V(p,k))))))),0),1.59635020230004))+(1.20292215806504e-05*pow(max(V(p,k)/686.339750712398*(max(686.339750712398*(0.170194043271609+V(g,k)/sqrt(154.542793692796+V(p,k)*V(p,k))),0)+ln(1+exp(-abs(686.339750712398*(0.170194043271609+V(g,k)/sqrt(154.542793692796+V(p,k)*V(p,k))))))),0),1.59635020230004))+(9.86920203956138e-06*pow(max(V(p,k)/686.339750712398*(max(686.339750712398*(0.182011808593297+V(g,k)/sqrt(154.542793692796+V(p,k)*V(p,k))),0)+ln(1+exp(-abs(686.339750712398*(0.182011808593297+V(g,k)/sqrt(154.542793692796+V(p,k)*V(p,k))))))),0),1.59635020230004))+(8.28861858623968e-06*pow(max(V(p,k)/686.339750712398*(max(686.339750712398*(0.193829573914985+V(g,k)/sqrt(154.542793692796+V(p,k)*V(p,k))),0)+ln(1+exp(-abs(686.339750712398*(0.193829573914985+V(g,k)/sqrt(154.542793692796+V(p,k)*V(p,k))))))),0),1.59635020230004))+(7.0948608758556e-06*pow(max(V(p,k)/686.339750712398*(max(686.339750712398*(0.205647339236674+V(g,k)/sqrt(154.542793692796+V(p,k)*V(p,k))),0)+ln(1+exp(-abs(686.339750712398*(0.205647339236674+V(g,k)/sqrt(154.542793692796+V(p,k)*V(p,k))))))),0),1.59635020230004))+(6.16273136779443e-06*pow(max(V(p,k)/686.339750712398*(max(686.339750712398*(0.217465104558362+V(g,k)/sqrt(154.542793692796+V(p,k)*V(p,k))),0)+ln(1+exp(-abs(686.339750712398*(0.217465104558362+V(g,k)/sqrt(154.542793692796+V(p,k)*V(p,k))))))),0),1.59635020230004))+(5.40849245931447e-06*pow(max(V(p,k)/686.339750712398*(max(686.339750712398*(0.229282869880051+V(g,k)/sqrt(154.542793692796+V(p,k)*V(p,k))),0)+ln(1+exp(-abs(686.339750712398*(0.229282869880051+V(g,k)/sqrt(154.542793692796+V(p,k)*V(p,k))))))),0),1.59635020230004))+(4.77484050926088e-06*pow(max(V(p,k)/686.339750712398*(max(686.339750712398*(0.241100635201739+V(g,k)/sqrt(154.542793692796+V(p,k)*V(p,k))),0)+ln(1+exp(-abs(686.339750712398*(0.241100635201739+V(g,k)/sqrt(154.542793692796+V(p,k)*V(p,k))))))),0),1.59635020230004))+(4.22208695293489e-06*pow(max(V(p,k)/686.339750712398*(max(686.339750712398*(0.252918400523428+V(g,k)/sqrt(154.542793692796+V(p,k)*V(p,k))),0)+ln(1+exp(-abs(686.339750712398*(0.252918400523428+V(g,k)/sqrt(154.542793692796+V(p,k)*V(p,k))))))),0),1.59635020230004))+(3.72294955380011e-06*pow(max(V(p,k)/686.339750712398*(max(686.339750712398*(0.264736165845116+V(g,k)/sqrt(154.542793692796+V(p,k)*V(p,k))),0)+ln(1+exp(-abs(686.339750712398*(0.264736165845116+V(g,k)/sqrt(154.542793692796+V(p,k)*V(p,k))))))),0),1.59635020230004))+(3.25945370449139e-06*pow(max(V(p,k)/686.339750712398*(max(686.339750712398*(0.276553931166805+V(g,k)/sqrt(154.542793692796+V(p,k)*V(p,k))),0)+ln(1+exp(-abs(686.339750712398*(0.276553931166805+V(g,k)/sqrt(154.542793692796+V(p,k)*V(p,k))))))),0),1.59635020230004))+(2.8210201083104e-06*pow(max(V(p,k)/686.339750712398*(max(686.339750712398*(0.288371696488493+V(g,k)/sqrt(154.542793692796+V(p,k)*V(p,k))),0)+ln(1+exp(-abs(686.339750712398*(0.288371696488493+V(g,k)/sqrt(154.542793692796+V(p,k)*V(p,k))))))),0),1.59635020230004))+(2.40312996410288e-06*pow(max(V(p,k)/686.339750712398*(max(686.339750712398*(0.300189461810181+V(g,k)/sqrt(154.542793692796+V(p,k)*V(p,k))),0)+ln(1+exp(-abs(686.339750712398*(0.300189461810181+V(g,k)/sqrt(154.542793692796+V(p,k)*V(p,k))))))),0),1.59635020230004))+(2.00615303714492e-06*pow(max(V(p,k)/686.339750712398*(max(686.339750712398*(0.31200722713187+V(g,k)/sqrt(154.542793692796+V(p,k)*V(p,k))),0)+ln(1+exp(-abs(686.339750712398*(0.31200722713187+V(g,k)/sqrt(154.542793692796+V(p,k)*V(p,k))))))),0),1.59635020230004))+(1.63407730111303e-06*pow(max(V(p,k)/686.339750712398*(max(686.339750712398*(0.323824992453558+V(g,k)/sqrt(154.542793692796+V(p,k)*V(p,k))),0)+ln(1+exp(-abs(686.339750712398*(0.323824992453558+V(g,k)/sqrt(154.542793692796+V(p,k)*V(p,k))))))),0),1.59635020230004))+(1.29303084179129e-06*pow(max(V(p,k)/686.339750712398*(max(686.339750712398*(0.335642757775247+V(g,k)/sqrt(154.542793692796+V(p,k)*V(p,k))),0)+ln(1+exp(-abs(686.339750712398*(0.335642757775247+V(g,k)/sqrt(154.542793692796+V(p,k)*V(p,k))))))),0),1.59635020230004))+(9.89643854211024e-07*pow(max(V(p,k)/686.339750712398*(max(686.339750712398*(0.347460523096935+V(g,k)/sqrt(154.542793692796+V(p,k)*V(p,k))),0)+ln(1+exp(-abs(686.339750712398*(0.347460523096935+V(g,k)/sqrt(154.542793692796+V(p,k)*V(p,k))))))),0),1.59635020230004))+(7.29438620985027e-07*pow(max(V(p,k)/686.339750712398*(max(686.339750712398*(0.359278288418624+V(g,k)/sqrt(154.542793692796+V(p,k)*V(p,k))),0)+ln(1+exp(-abs(686.339750712398*(0.359278288418624+V(g,k)/sqrt(154.542793692796+V(p,k)*V(p,k))))))),0),1.59635020230004))+(5.15518626672594e-07*pow(max(V(p,k)/686.339750712398*(max(686.339750712398*(0.371096053740312+V(g,k)/sqrt(154.542793692796+V(p,k)*V(p,k))),0)+ln(1+exp(-abs(686.339750712398*(0.371096053740312+V(g,k)/sqrt(154.542793692796+V(p,k)*V(p,k))))))),0),1.59635020230004))+(3.47817771575468e-07*pow(max(V(p,k)/686.339750712398*(max(686.339750712398*(0.382913819062001+V(g,k)/sqrt(154.542793692796+V(p,k)*V(p,k))),0)+ln(1+exp(-abs(686.339750712398*(0.382913819062001+V(g,k)/sqrt(154.542793692796+V(p,k)*V(p,k))))))),0),1.59635020230004))+(2.23057579777084e-07*pow(max(V(p,k)/686.339750712398*(max(686.339750712398*(0.394731584383689+V(g,k)/sqrt(154.542793692796+V(p,k)*V(p,k))),0)+ln(1+exp(-abs(686.339750712398*(0.394731584383689+V(g,k)/sqrt(154.542793692796+V(p,k)*V(p,k))))))),0),1.59635020230004))}
Bg g k I={0.004*pow(0.05*(max((V(g,k)-(-0.7))/0.05,0)+ln(1+exp(-abs((V(g,k)-(-0.7))/0.05)))),1.5)}
Cgk g k 8e-12
Cgp g p 4.8e-12
Cpk p k 4.4e-12
.ends TRIODE_6386_B

* 12AX7: generated by varimu.devices.triode
.subckt TRIODE_12AX7 p g k
Bp p k I={0.00188679245283019*pow(max(V(p,k)/600*(max(600*(0.01+V(g,k)/sqrt(300+V(p,k)*V(p,k))),0)+ln(1+exp(-abs(600*(0.01+V(g,k)/sqrt(300+V(p,k)*V(p,k))))))),0),1.4)}
Bg g k I={0.001*pow(0.05*(max((V(g,k)-(-0.7))/0.05,0)+ln(1+exp(-abs((V(g,k)-(-0.7))/0.05)))),1.5)}
Cgk g k 2.3e-12
Cgp g p 2.4e-12
Cpk p k 9e-13
.ends TRIODE_12AX7

* 12BH7: generated by varimu.devices.triode
.subckt TRIODE_12BH7 p g k
Bp p k I={0.00155813248215146*pow(max(V(p,k)/300*(max(300*(0.0608430480972899+V(g,k)/sqrt(300+V(p,k)*V(p,k))),0)+ln(1+exp(-abs(300*(0.0608430480972899+V(g,k)/sqrt(300+V(p,k)*V(p,k))))))),0),1.28480912610917)}
Bg g k I={0.001*pow(0.05*(max((V(g,k)-(-0.7))/0.05,0)+ln(1+exp(-abs((V(g,k)-(-0.7))/0.05)))),1.5)}
Cgk g k 3.2e-12
Cgp g p 2.6e-12
Cpk p k 5e-13
.ends TRIODE_12BH7

* 6973: generated by varimu.devices.pentode
.subckt PENTODE_6973 p g2 g1 k
Bp p k I={0.00104649484005964*pow(max(max(V(g2,k),0.001)/65.7217545417324*(max(65.7217545417324*(0.109199009749746+V(g1,k)/max(V(g2,k),0.001)),0)+ln(1+exp(-abs(65.7217545417324*(0.109199009749746+V(g1,k)/max(V(g2,k),0.001)))))),0),1.35)*atan(V(p,k)/27.5247648157089)}
Bg2 g2 k I={pow(max(V(g1,k)+V(g2,k)/9.15759220062275,0),1.5)/12324.7043795843}
Cg1k g1 k 9e-12
Cg1p g1 p 4e-13
Cpk p k 6e-12
.ends PENTODE_6973

.model D_SI_RECTIFIER D(IS=7e-09 N=1.8 RS=0.034)

* --- power supply ---
VBP bpi 0 dc 240
Rpsu bpi bp 10
C307A bp 0 8e-05
VBIAS vbi 0 dc -13.75
Rbias vbi vb 100
VSCB vsc 0 dc -27
* --- input ---
Rsrc in in_s 600
RAT1011 in_s AT101_m 311.696311977549
RAT1012 AT101_m pri 311.696311977549
RAT1013 AT101_m 0 421.637021355784
R101 pri 0 360
RT101_p pri T101_p_r 20
LT101_p T101_p_r 0 10
RT101_sa ga T101_sa_r 400
LT101_sa T101_sa_r cv 202.5
CT101_sa ga cv 1e-10
RT101_sa_loss ga cv 200000
RT101_sb cv T101_sb_r 400
LT101_sb T101_sb_r gb 202.5
CT101_sb cv gb 1e-10
RT101_sb_loss cv gb 200000
KT101_p_sa LT101_p LT101_sa 0.999
KT101_p_sb LT101_p LT101_sb 0.999
KT101_sa_sb LT101_sa LT101_sb 0.999
* --- 6386 push-pull ---
XVA pa ga ka TRIODE_6386_A
XVB pb gb kb TRIODE_6386_B
R103 ka ta 680
R104 kb tb 680
R105a ta 0 50
R105b 0 tb 50
C101 ka kb 4e-06
R111 bp ctr 33
R107 ctr t3 30
R108 ctr t2 30
RT102_pa pa T102_pa_r 150
LT102_pa T102_pa_r t3 30
CT102_pa pa t3 2e-10
RT102_pa_loss pa t3 50000
RT102_pb t2 T102_pb_r 150
LT102_pb T102_pb_r pb 30
CT102_pb t2 pb 2e-10
RT102_pb_loss t2 pb 50000
RT102_s out T102_s_r 10
LT102_s T102_s_r 0 1.48148148148148
KT102_pa_pb LT102_pa LT102_pb 0.999
KT102_pa_s LT102_pa LT102_s 0.999
KT102_pb_s LT102_pb LT102_s 0.999
Rload out 0 600
* --- sidechain input ---
R145 out s1 150
R147 0 s2 150
R149 s1 s2 1360
RT103_p s1 T103_p_r 0.001
LT103_p T103_p_r s2 5
RT103_sa t5 T103_sa_r 0.001
LT103_sa T103_sa_r 0 45
CT103_sa t5 0 1e-10
RT103_sb 0 T103_sb_r 0.001
LT103_sb T103_sb_r t8 45
CT103_sb 0 t8 1e-10
KT103_p_sa LT103_p LT103_sa 0.999
KT103_p_sb LT103_p LT103_sb 0.999
KT103_sa_sb LT103_sa LT103_sb 0.999
R115Aa t5 w1a 50000
R115Ab w1a x1a 50000
R115Ba t8 w1b 90000
R115Bb w1b x1b 90000
R113 x1a 0 24000
R114 x1b 0 24000
* --- 12AX7 ---
XV105A p1a w1a k1 TRIODE_12AX7
XV105B p1b w1b k1 TRIODE_12AX7
R120 bp p1a 100000
R121 bp p1b 100000
R118 bp k1 1000000
R119 k1 0 18000
R116 bp dw 270000
R117a 0 dw 0.001
R117b dw k1 100000
C103 p1a g2a 5e-08
C104 p1b g2b 5e-08
* --- 12BH7 ---
R122 g2a 0 1000000
R123 g2b 0 1000000
XV106A p2a g2a k2a TRIODE_12BH7
XV106B p2b g2b k2b TRIODE_12BH7
R124 k2a 0 1000
R125 k2b 0 1000
R126 bp p2a 100000
R127 bp p2b 100000
Rfba fy k2a 2700
Rfbb fg k2b 2700
R134 fy 0 860
R135 fg 0 560
C107 p2a g3a 1e-07
C108 p2b g3b 1e-07
* --- 6973 ---
R130 g3a vsc 150000
R131 g3b vsc 150000
XV107 pa3 sa3 g3a 0 PENTODE_6973
XV108 pb3 sb3 g3b 0 PENTODE_6973
R132 bp sa3 560
R133 bp sb3 560
R143 g3a nfa 47000
C105 nfa pa3 2e-11
R144 g3b nfb 47000
C106 nfb pb3 2e-11
RT104_pa pa3 T104_pa_r 0.001
LT104_pa T104_pa_r bp 10
CT104_pa pa3 bp 2e-10
RT104_pa_loss pa3 bp 50000
RT104_pb bp T104_pb_r 0.001
LT104_pb T104_pb_r pb3 10
CT104_pb bp pb3 2e-10
RT104_pb_loss bp pb3 50000
RT104_s ay T104_s_r 0.001
LT104_s T104_s_r bk 2.5
RT104_f fy T104_f_r 0.001
LT104_f T104_f_r fg 0.4431025
KT104_pa_pb LT104_pa LT104_pb 0.999
KT104_pa_s LT104_pa LT104_s 0.999
KT104_pa_f LT104_pa LT104_f 0.999
KT104_pb_s LT104_pb LT104_s 0.999
KT104_pb_f LT104_pb LT104_f 0.999
KT104_s_f LT104_s LT104_f 0.999
* --- rectifier and time constant ---
R136 ay bk 3900
Rleak bk 0 1000000000
DCR101 ay tcb D_SI_RECTIFIER
DCR102 bk tcb D_SI_RECTIFIER
DCR103 cv ay D_SI_RECTIFIER
DCR104 cv bk D_SI_RECTIFIER
R137 cv tcb 220000
C109 cv tcb 2e-06
R139 cv tc139 100000
C110 tc139 tcb 8e-06
R140 cv tc140 100000
C112 tc140 tcb 2e-05
C115 tcb 0 1e-07
R142a 0 tcb 750
R142b tcb vb 1750
